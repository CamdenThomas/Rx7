* ladder_a2.cir - the wiper stalk ladder (ladders A2 *, inputs A2) read by the PMU's ground-type
* input: its 10 k pull-up to 5 V, 10-bit (S-028; D-381). The WASH leg is the odd one: its
* contact also grounds K12's coil, so a diode keeps the coil's 12 V off the ladder line. While
* WASH is not pressed that diode sits reverse-biased by the whole battery voltage, and its
* leakage lands on the line - R12 found a hot 1N5819 lifts the OFF reading past the fault line.
*
* Pass, at -30 / 25 / 85 C with the coil at 16 V: the five states read in order OFF > INT >
* LOW > HIGH > WASH with at least 2 x inputs.window (45 counts) + 10 between neighbours; every
* state sits inside the fault lines (50 short, 990 open) by >= 20 counts; and the OFF reading
* with the diode hot stays within the window of the OFF reading cold. The old leg (1.8 k +
* 1N5819) is run the same way and printed, not judged, so the record shows what it did.
.include models/active.lib

* the PMU input: 10 k to 5 V, read as counts = v / 5 x 1023
V5 ref 0 dc 5
RPU ref line 10k
* the ladder at the column: the 47 k baseline, and one resistor per state that `alter` makes
* present (its value) or absent (1e12)
R47 line 0 47k
RINT line 0 1e12
RLOW line 0 1e12
RHIGH line 0 1e12
* WASH: 470 ohm and a 1N4148 (R12; 1.0 k left WASH 90 counts from HIGH at -30 C) to the contact node; K12's coil (160 ohm, P003 class) holds
* that node at battery voltage while the contact is open; RWASH is the contact
RW line n_w 470
DW n_w wash D1N4148
RCOIL vbat wash 160
VBAT vbat 0 dc 16
RWASH wash 0 1e12
.op

.control
set fail = 0
set deck = ladder_a2
set win = 45
set need = 100
foreach t -30 25 85
  set temp = $t
  alter rint 1e12
  alter rlow 1e12
  alter rhigh 1e12
  alter rwash 1e12
  op
  let c = v(line) / 5 * 1023
  set c_off = $&c
  alter rint 18k
  op
  let c = v(line) / 5 * 1023
  set c_int = $&c
  alter rint 1e12
  alter rlow 10k
  op
  let c = v(line) / 5 * 1023
  set c_low = $&c
  alter rlow 1e12
  alter rhigh 4.7k
  op
  let c = v(line) / 5 * 1023
  set c_high = $&c
  alter rhigh 1e12
  alter rwash 0.1
  op
  let c = v(line) / 5 * 1023
  set c_wash = $&c
  alter rwash 1e12
  let g1 = $c_off - $c_int
  let g2 = $c_int - $c_low
  let g3 = $c_low - $c_high
  let g4 = $c_high - $c_wash
  if g1 < $need
    echo FAIL $deck t=$t OFF-INT gap=$&g1
    set fail = 1
  end
  if g2 < $need
    echo FAIL $deck t=$t INT-LOW gap=$&g2
    set fail = 1
  end
  if g3 < $need
    echo FAIL $deck t=$t LOW-HIGH gap=$&g3
    set fail = 1
  end
  if g4 < $need
    echo FAIL $deck t=$t HIGH-WASH gap=$&g4
    set fail = 1
  end
  if $c_wash < 70
    echo FAIL $deck t=$t WASH near the short line counts=$c_wash
    set fail = 1
  end
  if $c_off > 970
    echo FAIL $deck t=$t OFF near the open line counts=$c_off
    set fail = 1
  end
  if $t = -30
    set c_off_cold = $c_off
  end
  let drift = $c_off - $c_off_cold
  if drift > $win
    echo FAIL $deck t=$t OFF drifted by $&drift counts with the diode hot
    set fail = 1
  end
  echo INFO $deck t=$t OFF=$c_off INT=$c_int LOW=$c_low HIGH=$c_high WASH=$c_wash
end
* --- the old leg, 1.8 k + 1N5819 (D-381), printed for the record ---
alter rw 1.8k
alter @dw[model] = D1N5819
foreach t -30 25 85
  set temp = $t
  alter rwash 1e12
  op
  let c = v(line) / 5 * 1023
  set c_off = $&c
  alter rwash 0.1
  op
  let c = v(line) / 5 * 1023
  set c_wash = $&c
  alter rwash 1e12
  echo INFO $deck old-1N5819 t=$t OFF=$c_off WASH=$c_wash
end
if $fail = 1
  quit 1
end
echo PASS $deck
quit 0
.endc
.end
